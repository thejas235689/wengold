reg {
    field { sw=rw; hw=r; } SEC_KEY[31:0] = 0;
    field { sw=rw; hw=r; } SEC_EN[0:0] = 0;
} sec_ctrl @ 0x00020000;
